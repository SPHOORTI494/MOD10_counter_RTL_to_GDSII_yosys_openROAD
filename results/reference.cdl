* CDL Netlist generated by OpenROAD

*.BUSDELIMITER [

.SUBCKT mod10_counter clk count[0] count[1] count[2] count[3]
+ rst VDD VSS
X_10_ rst VSS VSS VDD VDD _01_ sky130_fd_sc_hd__clkinv_1
X_11_ count[0] VSS VSS VDD VDD _00_[0] sky130_fd_sc_hd__clkinv_1
X_12_ count[1] count[0] VSS VSS VDD VDD _05_ sky130_fd_sc_hd__nand2_1
X_13_ count[2] count[1] count[3] count[0] VSS VSS VDD VDD
+ _06_ sky130_fd_sc_hd__and4_1
X_14_ count[2] count[1] count[3] count[0] VSS VSS VDD VDD
+ _07_ sky130_fd_sc_hd__nor4bb_1
X_15_ count[2] count[1] count[0] count[3] VSS VSS VDD VDD
+ _08_ sky130_fd_sc_hd__a31oi_1
X_16_ _06_ _07_ _08_ VSS VSS VDD VDD _00_[3] sky130_fd_sc_hd__nor3_1
X_17_ count[2] _05_ VSS VSS VDD VDD _00_[2] sky130_fd_sc_hd__xnor2_1
X_18_ count[1] count[0] VSS VSS VDD VDD _09_ sky130_fd_sc_hd__xnor2_1
X_19_ _07_ _09_ VSS VSS VDD VDD _00_[1] sky130_fd_sc_hd__nor2_1
X_20_ rst VSS VSS VDD VDD _02_ sky130_fd_sc_hd__clkinv_1
X_21_ rst VSS VSS VDD VDD _03_ sky130_fd_sc_hd__clkinv_1
X_22_ rst VSS VSS VDD VDD _04_ sky130_fd_sc_hd__clkinv_1
X_23_ clknet_1_1__leaf_clk _00_[0] _02_ VSS VSS VDD VDD count[0]
+ sky130_fd_sc_hd__dfrtp_1
X_24_ clknet_1_0__leaf_clk _00_[1] _01_ VSS VSS VDD VDD count[1]
+ sky130_fd_sc_hd__dfrtp_1
X_25_ clknet_1_0__leaf_clk _00_[2] _03_ VSS VSS VDD VDD count[2]
+ sky130_fd_sc_hd__dfrtp_1
X_26_ clknet_1_1__leaf_clk _00_[3] _04_ VSS VSS VDD VDD count[3]
+ sky130_fd_sc_hd__dfrtp_1
XTAP_TAPCELL_ROW_0_0 VSS VDD sky130_fd_sc_hd__tapvpwrvgnd_1
XTAP_TAPCELL_ROW_0_1 VSS VDD sky130_fd_sc_hd__tapvpwrvgnd_1
XTAP_TAPCELL_ROW_1_2 VSS VDD sky130_fd_sc_hd__tapvpwrvgnd_1
XTAP_TAPCELL_ROW_2_3 VSS VDD sky130_fd_sc_hd__tapvpwrvgnd_1
XTAP_TAPCELL_ROW_3_4 VSS VDD sky130_fd_sc_hd__tapvpwrvgnd_1
XTAP_TAPCELL_ROW_4_5 VSS VDD sky130_fd_sc_hd__tapvpwrvgnd_1
XTAP_TAPCELL_ROW_5_6 VSS VDD sky130_fd_sc_hd__tapvpwrvgnd_1
XTAP_TAPCELL_ROW_6_7 VSS VDD sky130_fd_sc_hd__tapvpwrvgnd_1
XTAP_TAPCELL_ROW_7_8 VSS VDD sky130_fd_sc_hd__tapvpwrvgnd_1
XTAP_TAPCELL_ROW_8_9 VSS VDD sky130_fd_sc_hd__tapvpwrvgnd_1
XTAP_TAPCELL_ROW_9_10 VSS VDD sky130_fd_sc_hd__tapvpwrvgnd_1
XTAP_TAPCELL_ROW_10_11 VSS VDD sky130_fd_sc_hd__tapvpwrvgnd_1
XTAP_TAPCELL_ROW_11_12 VSS VDD sky130_fd_sc_hd__tapvpwrvgnd_1
XTAP_TAPCELL_ROW_12_13 VSS VDD sky130_fd_sc_hd__tapvpwrvgnd_1
XTAP_TAPCELL_ROW_13_14 VSS VDD sky130_fd_sc_hd__tapvpwrvgnd_1
XTAP_TAPCELL_ROW_13_15 VSS VDD sky130_fd_sc_hd__tapvpwrvgnd_1
Xclkbuf_0_clk clk _unconnected_0 _unconnected_1 _unconnected_2
+ _unconnected_3 clknet_0_clk sky130_fd_sc_hd__clkbuf_1
Xclkbuf_1_0__f_clk clknet_0_clk _unconnected_4 _unconnected_5
+ _unconnected_6 _unconnected_7 clknet_1_0__leaf_clk sky130_fd_sc_hd__clkbuf_1
Xclkbuf_1_1__f_clk clknet_0_clk _unconnected_8 _unconnected_9
+ _unconnected_10 _unconnected_11 clknet_1_1__leaf_clk sky130_fd_sc_hd__clkbuf_1
.ENDS mod10_counter
